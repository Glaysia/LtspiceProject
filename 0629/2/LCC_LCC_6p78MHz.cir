* LCC-LCC @ 6.78MHz  Vin=288Vrms  out=100V/5.0A
Vin S 0 SINE(0 407.4 6780000)
* -- primary LCC --
Lf1 S  P1 4.142e-07
Cf1 P1 0  1.141e-09
C1  P1 T1 2.829e-10
Rtx T1 Tm 0.09362
Ltx Tm 0  2.362e-06
* -- secondary LCC --
Lrx Rm 0  2.509e-06
Rrx Rx Rm 0.05745
C2  Rx P2 2.319e-10
Cf2 P2 0  4.133e-09
Lf2 P2 Lo 1.333e-07
RL  Lo 0  20
K1  Ltx Lrx 0.0198
.ac lin 401 6237600 7322400
.end
