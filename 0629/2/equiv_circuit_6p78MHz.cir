* HFSS 등가회로 @ 6.78 MHz  (각 코일: (R1+L)//C//R2)
* ---- Tx ----
R1t N1  Na 0.06259
Ltx Na 0  2.308e-06
Ctx N1 0  5.475e-12
R2t N1 0  3.609e+05
* ---- Rx ----
R1r N2 Nb 0.03798
Lrx Nb 0  2.374e-06
Crx N2 0  1.248e-11
R2r N2 0  7.605e+05
* ---- coupling ----
K1 Ltx Lrx 0.0206
