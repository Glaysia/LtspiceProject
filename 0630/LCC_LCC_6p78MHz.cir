* LCC-LCC @ 6.78MHz  Vin=288Vrms  RL=50ohm  out~158V/3.2A
Vin S 0 SINE(0 407.4 6780000)
* --- primary LCC ---
Lf1 S  P1 3.297e-07
Cf1 P1 0  1.489e-09
C1  P1 T1 3.586e-10
* Tx coil (L+R1)//Cself//R2
Ctx T1 0  6.987e-12
R2t T1 0  2.325e+05
R1t T1 Tm 0.0289
Ltx Tm 0  1.823e-06
* Rx coil
Crx Rn 0  1.353e-11
R2r Rn 0  4.112e+05
R1r Rn Rm 0.06842
Lrx Rm 0  3.165e-06
* --- secondary LCC ---
C2  Rn P2 1.769e-10
Cf2 P2 0  1.744e-09
Lf2 P2 Lo 3.16e-07
RL  Lo 0  50
K1  Ltx Lrx -0.0233
.ac lin 401 6237600 7322400
.end
